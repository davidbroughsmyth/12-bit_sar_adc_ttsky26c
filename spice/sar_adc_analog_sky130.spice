* Sky130 analog top: pads vin_ecg, vref + S/H, R-2R, StrongARM comparator.
.subckt sar_adc_analog_sky130
+ vin_ecg vref
+ sample_en
+ dac0 dac1 dac2 dac3 dac4 dac5 dac6 dac7 dac8 dac9 dac10 dac11
+ comp_p clk_cmp
+ avdd avss

Xsh  vin_ecg vhold sample_en avdd avss sample_hold_sky130
Xdac dac0 dac1 dac2 dac3 dac4 dac5 dac6 dac7 dac8 dac9 dac10 dac11
+    vdac vref avss avdd r2r_dac_sky130
Xcmp vhold vdac clk_cmp comp_p avdd avss comparator_sky130
.ends
