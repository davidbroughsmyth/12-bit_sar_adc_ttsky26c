* Sky130 sample/hold: 3.3 V TG + MIM hold cap.
.subckt sample_hold_sky130 vin_ecg vhold sample_en avdd avss
Xinv_n sen sample_en avss avss sky130_fd_pr__nfet_g5v0d10v5 W=1.0 L=0.5
Xinv_p sen sample_en avdd avdd sky130_fd_pr__pfet_g5v0d10v5 W=2.0 L=0.5
Xn    vin_ecg sample_en vhold avss sky130_fd_pr__nfet_g5v0d10v5 W=8.0 L=0.5
Xp    vin_ecg sen       vhold avdd sky130_fd_pr__pfet_g5v0d10v5 W=16.0 L=0.5
Xch   vhold avss sky130_fd_pr__cap_mim_m3_1 W=30 L=30
Rleak vhold avss 50G
.ends
